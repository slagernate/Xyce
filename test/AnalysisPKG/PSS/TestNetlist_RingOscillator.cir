* Ring Oscillator for Autonomous PSS Test
* Simple 3-stage ring oscillator
* Stage 1
VDD 1 0 5
R1 1 2 1k
C1 2 0 1p
* Stage 2
R2 1 3 1k
C2 3 0 1p
* Stage 3
R3 1 4 1k
C3 4 0 1p
* Coupling (simplified)
G1 2 0 3 0 0.001
G2 3 0 4 0 0.001
G3 4 0 2 0 0.001
.PSS 1u AUTONOMOUS REFNODE=2
.PRINT PSS V(2) V(3) V(4)
.END
