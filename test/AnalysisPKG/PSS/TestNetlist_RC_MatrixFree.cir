* Simple RC circuit with PSS matrix-free options
V1 1 0 SIN(0 1 1e6)
R1 1 2 1k
C1 2 0 1n
.PSS 1u MATRIXFREE GMRESRESTART=10 GMRESMAXITER=10 GMRESTOL=0.01 GMRESPRECOND=DIAG GMRESPRECONDMAX=50 GMRESLOG
.PRINT PSS V(2) I(V1)
.END
