* RLC circuit for PSS testing
* RLC circuit with periodic voltage source

V1 1 0 SIN(0 1 1e6)  ; 1MHz, 1V amplitude
R1 1 2 100
L1 2 3 1u
C1 3 0 1n

.PSS 1u
.PRINT PSS V(2) V(3) I(V1)

.END
